* NGSPICE file created from alu_4bit.ext - technology: scmos

* Black-box entry subcircuit for NAND2X1 abstract view
.subckt NAND2X1 A B gnd Y vdd
.ends

* Black-box entry subcircuit for OAI22X1 abstract view
.subckt OAI22X1 A B C D gnd Y vdd
.ends

* Black-box entry subcircuit for OAI21X1 abstract view
.subckt OAI21X1 A B C gnd Y vdd
.ends

* Black-box entry subcircuit for FILL abstract view
.subckt FILL gnd vdd
.ends

* Black-box entry subcircuit for INVX1 abstract view
.subckt INVX1 A gnd Y vdd
.ends

* Black-box entry subcircuit for AOI22X1 abstract view
.subckt AOI22X1 A B C D gnd Y vdd
.ends

* Black-box entry subcircuit for NOR3X1 abstract view
.subckt NOR3X1 A B C gnd Y vdd
.ends

* Black-box entry subcircuit for NAND3X1 abstract view
.subckt NAND3X1 A B C gnd Y vdd
.ends

* Black-box entry subcircuit for BUFX2 abstract view
.subckt BUFX2 A gnd Y vdd
.ends

* Black-box entry subcircuit for INVX2 abstract view
.subckt INVX2 A gnd Y vdd
.ends

* Black-box entry subcircuit for AOI21X1 abstract view
.subckt AOI21X1 A B C gnd Y vdd
.ends

* Black-box entry subcircuit for NOR2X1 abstract view
.subckt NOR2X1 A B gnd Y vdd
.ends

* Black-box entry subcircuit for XNOR2X1 abstract view
.subckt XNOR2X1 A B gnd Y vdd
.ends

* Black-box entry subcircuit for AND2X2 abstract view
.subckt AND2X2 A B gnd Y vdd
.ends

* Black-box entry subcircuit for OR2X2 abstract view
.subckt OR2X2 A B gnd Y vdd
.ends

.subckt alu_4bit vdd gnd A[0] A[1] A[2] A[3] B[0] B[1] B[2] B[3] ALU_Sel[0] ALU_Sel[1]
+ ALU_Sel[2] Cin Y[0] Y[1] Y[2] Y[3] Cout Zero
XNAND2X1_21 INVX1_19/Y NOR2X1_15/Y gnd OAI21X1_21/C vdd NAND2X1
XOAI22X1_3 A[2] INVX1_10/A INVX1_17/A INVX1_6/A gnd OAI22X1_3/Y vdd OAI22X1
XNAND2X1_10 B[1] A[1] gnd INVX1_14/A vdd NAND2X1
XOAI21X1_19 B[3] A[3] NOR2X1_2/Y gnd OAI21X1_22/A vdd OAI21X1
XFILL_0_0_0 gnd vdd FILL
XINVX1_6 INVX1_6/A gnd INVX1_6/Y vdd INVX1
XAOI22X1_1 INVX1_4/Y OAI21X1_4/B OAI21X1_6/Y AOI22X1_1/D gnd AOI22X1_1/Y vdd AOI22X1
XNAND2X1_11 A[0] A[1] gnd INVX1_11/A vdd NAND2X1
XFILL_0_0_1 gnd vdd FILL
XINVX1_7 A[0] gnd INVX1_7/Y vdd INVX1
XNAND2X1_12 INVX1_7/Y INVX1_9/Y gnd NAND3X1_11/B vdd NAND2X1
XAOI22X1_2 INVX1_10/Y INVX2_1/Y INVX1_6/Y NOR2X1_17/A gnd AOI22X1_2/Y vdd AOI22X1
XFILL_0_0_2 gnd vdd FILL
XINVX1_8 B[1] gnd INVX1_8/Y vdd INVX1
XAOI22X1_3 AOI22X1_3/A AOI22X1_3/B INVX1_22/Y AOI22X1_3/D gnd AOI22X1_3/Y vdd AOI22X1
XNOR3X1_1 OR2X2_2/B BUFX2_2/A OR2X2_2/A gnd NOR3X1_1/Y vdd NOR3X1
XNAND2X1_13 B[2] A[2] gnd INVX1_17/A vdd NAND2X1
XFILL_3_0_0 gnd vdd FILL
XINVX1_9 A[1] gnd INVX1_9/Y vdd INVX1
XNAND2X1_14 INVX1_12/Y INVX1_13/Y gnd AND2X2_3/A vdd NAND2X1
XFILL_3_0_1 gnd vdd FILL
XNAND2X1_15 INVX1_17/A AND2X2_3/A gnd OAI21X1_7/A vdd NAND2X1
XFILL_3_0_2 gnd vdd FILL
XNAND2X1_16 INVX1_13/Y NOR2X1_9/Y gnd NOR2X1_15/B vdd NAND2X1
XNAND3X1_1 Cin OAI21X1_3/C OR2X2_1/Y gnd NAND3X1_2/B vdd NAND3X1
XFILL_1_1_0 gnd vdd FILL
XNAND3X1_2 OAI21X1_1/Y NAND3X1_2/B NOR2X1_2/Y gnd NAND3X1_5/A vdd NAND3X1
XNAND2X1_17 OAI21X1_11/Y NOR2X1_15/B gnd AOI21X1_8/B vdd NAND2X1
XFILL_1_1_1 gnd vdd FILL
XNAND3X1_3 ALU_Sel[1] INVX1_5/Y INVX1_3/Y gnd INVX1_6/A vdd NAND3X1
XNAND2X1_18 OAI21X1_7/Y AOI21X1_9/Y gnd BUFX2_4/A vdd NAND2X1
XFILL_1_1_2 gnd vdd FILL
XFILL_4_1_0 gnd vdd FILL
XFILL_5_1 gnd vdd FILL
XNAND3X1_4 ALU_Sel[1] ALU_Sel[0] INVX1_5/Y gnd OAI22X1_2/A vdd NAND3X1
XOAI21X1_1 NOR2X1_3/A NOR2X1_3/B INVX1_1/Y gnd OAI21X1_1/Y vdd OAI21X1
XNAND2X1_19 A[2] INVX1_12/Y gnd OAI21X1_15/C vdd NAND2X1
XFILL_4_1_1 gnd vdd FILL
XNAND3X1_5 NAND3X1_5/A OAI21X1_2/Y NAND3X1_5/C gnd BUFX2_2/A vdd NAND3X1
XOAI21X1_2 NOR2X1_4/Y INVX1_4/Y NOR2X1_3/Y gnd OAI21X1_2/Y vdd OAI21X1
XFILL_4_1_2 gnd vdd FILL
XNAND3X1_6 NAND3X1_6/A NAND3X1_6/B NAND3X1_6/C gnd NAND3X1_7/B vdd NAND3X1
XOAI21X1_3 INVX1_1/Y NOR2X1_3/A OAI21X1_3/C gnd OAI21X1_4/A vdd OAI21X1
XBUFX2_1 BUFX2_1/A gnd Cout vdd BUFX2
XNAND3X1_7 NOR2X1_4/Y NAND3X1_7/B OAI21X1_5/Y gnd NAND3X1_7/Y vdd NAND3X1
XINVX2_1 A[3] gnd INVX2_1/Y vdd INVX2
XAOI21X1_1 NOR2X1_3/B INVX1_6/Y OAI22X1_1/Y gnd NAND3X1_5/C vdd AOI21X1
XOAI21X1_4 OAI21X1_4/A OAI21X1_4/B NOR2X1_2/Y gnd OAI21X1_4/Y vdd OAI21X1
XNAND3X1_8 ALU_Sel[2] ALU_Sel[0] INVX1_2/Y gnd INVX1_10/A vdd NAND3X1
XBUFX2_2 BUFX2_2/A gnd Y[0] vdd BUFX2
XAOI21X1_2 OAI21X1_4/B OAI21X1_4/A OAI21X1_4/Y gnd OR2X2_2/B vdd AOI21X1
XAOI21X1_10 OR2X2_1/Y Cin NOR2X1_3/B gnd OAI21X1_13/B vdd AOI21X1
XOAI21X1_5 NOR2X1_6/Y NOR2X1_7/Y AND2X2_2/Y gnd OAI21X1_5/Y vdd OAI21X1
XNAND3X1_9 ALU_Sel[2] ALU_Sel[1] ALU_Sel[0] gnd INVX1_19/A vdd NAND3X1
XBUFX2_3 OR2X2_2/Y gnd Y[1] vdd BUFX2
XOAI21X1_6 NOR2X1_9/Y INVX1_11/Y INVX1_19/A gnd OAI21X1_6/Y vdd OAI21X1
XAOI21X1_3 INVX1_9/Y INVX1_10/Y OAI22X1_2/Y gnd AOI21X1_3/Y vdd AOI21X1
XAOI21X1_11 OAI21X1_13/Y OR2X2_3/B INVX1_17/Y gnd OAI21X1_14/B vdd AOI21X1
XNOR2X1_1 B[0] A[0] gnd NOR2X1_3/A vdd NOR2X1
XFILL_2_0_0 gnd vdd FILL
XNOR2X1_2 ALU_Sel[2] NOR2X1_2/B gnd NOR2X1_2/Y vdd NOR2X1
XAOI21X1_4 OAI21X1_4/B OAI21X1_4/A INVX1_14/Y gnd OAI21X1_7/B vdd AOI21X1
XBUFX2_4 BUFX2_4/A gnd Y[2] vdd BUFX2
XOAI21X1_7 OAI21X1_7/A OAI21X1_7/B OAI21X1_7/C gnd OAI21X1_7/Y vdd OAI21X1
XAOI21X1_12 OAI21X1_20/C INVX1_21/Y INVX1_16/Y gnd AOI21X1_15/A vdd AOI21X1
XFILL_1_1 gnd vdd FILL
XFILL_2_0_1 gnd vdd FILL
XAOI21X1_13 NOR2X1_9/Y INVX1_13/Y INVX2_1/Y gnd OAI21X1_16/A vdd AOI21X1
XOAI21X1_8 INVX1_17/Y INVX1_4/A OAI22X1_2/A gnd OAI21X1_9/C vdd OAI21X1
XNOR2X1_3 NOR2X1_3/A NOR2X1_3/B gnd NOR2X1_3/Y vdd NOR2X1
XAOI21X1_5 OAI21X1_7/B OAI21X1_7/A INVX1_15/Y gnd OAI21X1_7/C vdd AOI21X1
XBUFX2_5 BUFX2_5/A gnd Y[3] vdd BUFX2
XFILL_2_0_2 gnd vdd FILL
XNAND2X1_1 INVX1_2/Y INVX1_3/Y gnd NOR2X1_2/B vdd NAND2X1
XFILL_0_1_0 gnd vdd FILL
XBUFX2_6 BUFX2_6/A gnd Zero vdd BUFX2
XAOI21X1_6 NAND3X1_6/B NAND3X1_6/C NOR2X1_6/Y gnd OR2X2_3/A vdd AOI21X1
XOAI21X1_9 B[2] A[2] OAI21X1_9/C gnd OAI21X1_9/Y vdd OAI21X1
XNOR2X1_4 ALU_Sel[2] NOR2X1_4/B gnd NOR2X1_4/Y vdd NOR2X1
XAOI21X1_14 INVX2_1/Y INVX1_18/A NOR2X1_10/A gnd AOI22X1_3/B vdd AOI21X1
XNOR2X1_5 ALU_Sel[1] ALU_Sel[0] gnd NOR2X1_5/Y vdd NOR2X1
XNAND2X1_2 B[0] A[0] gnd OAI21X1_3/C vdd NAND2X1
XAOI21X1_7 OR2X2_3/A OR2X2_3/B INVX1_16/Y gnd AOI21X1_9/A vdd AOI21X1
XFILL_0_1_1 gnd vdd FILL
XAOI21X1_15 AOI21X1_15/A NAND3X1_15/Y NAND3X1_16/Y gnd OAI21X1_18/C vdd AOI21X1
XAOI21X1_8 INVX1_19/Y AOI21X1_8/B OAI22X1_3/Y gnd AOI21X1_8/Y vdd AOI21X1
XNAND2X1_3 ALU_Sel[0] INVX1_2/Y gnd NOR2X1_4/B vdd NAND2X1
XFILL_0_1_2 gnd vdd FILL
XNOR2X1_6 B[1] INVX1_9/Y gnd NOR2X1_6/Y vdd NOR2X1
XAOI21X1_16 INVX1_20/Y A[3] INVX1_16/Y gnd AOI21X1_17/B vdd AOI21X1
XFILL_3_1_0 gnd vdd FILL
XNAND2X1_4 ALU_Sel[2] NOR2X1_5/Y gnd INVX1_4/A vdd NAND2X1
XAOI21X1_17 OAI21X1_20/Y AOI21X1_17/B OAI21X1_21/Y gnd OAI21X1_22/C vdd AOI21X1
XAOI21X1_9 AOI21X1_9/A OR2X2_3/Y AOI21X1_9/C gnd AOI21X1_9/Y vdd AOI21X1
XNOR2X1_7 A[1] INVX1_8/Y gnd NOR2X1_7/Y vdd NOR2X1
XFILL_3_1_1 gnd vdd FILL
XNAND2X1_5 ALU_Sel[2] INVX1_7/Y gnd OAI22X1_1/B vdd NAND2X1
XNOR2X1_8 B[1] A[1] gnd NOR2X1_8/Y vdd NOR2X1
XINVX1_20 B[3] gnd INVX1_20/Y vdd INVX1
XNOR2X1_9 A[0] A[1] gnd NOR2X1_9/Y vdd NOR2X1
XFILL_3_1_2 gnd vdd FILL
XINVX1_10 INVX1_10/A gnd INVX1_10/Y vdd INVX1
XINVX1_21 INVX1_21/A gnd INVX1_21/Y vdd INVX1
XNAND2X1_6 A[1] INVX1_8/Y gnd NAND3X1_6/A vdd NAND2X1
XNAND2X1_7 B[1] INVX1_9/Y gnd NAND3X1_6/B vdd NAND2X1
XINVX1_22 INVX1_22/A gnd INVX1_22/Y vdd INVX1
XINVX1_11 INVX1_11/A gnd INVX1_11/Y vdd INVX1
XNAND2X1_8 NAND3X1_6/A NAND3X1_6/B gnd OAI21X1_4/B vdd NAND2X1
XINVX1_12 B[2] gnd INVX1_12/Y vdd INVX1
XNAND3X1_10 ALU_Sel[2] ALU_Sel[1] INVX1_3/Y gnd NOR2X1_10/A vdd NAND3X1
XNOR2X1_10 NOR2X1_10/A INVX1_18/Y gnd NOR2X1_10/Y vdd NOR2X1
XINVX1_13 A[2] gnd INVX1_13/Y vdd INVX1
XNAND2X1_9 B[0] INVX1_7/Y gnd NAND3X1_6/C vdd NAND2X1
XFILL_1_0_0 gnd vdd FILL
XNAND3X1_11 INVX1_11/A NAND3X1_11/B NOR2X1_10/A gnd AOI22X1_1/D vdd NAND3X1
XNOR2X1_11 B[3] A[3] gnd INVX1_22/A vdd NOR2X1
XINVX1_14 INVX1_14/A gnd INVX1_14/Y vdd INVX1
XOAI21X1_20 INVX1_20/Y A[3] OAI21X1_20/C gnd OAI21X1_20/Y vdd OAI21X1
XFILL_1_0_1 gnd vdd FILL
XNOR2X1_12 INVX1_20/Y INVX2_1/Y gnd NOR2X1_17/A vdd NOR2X1
XNAND3X1_12 NAND3X1_7/Y AOI22X1_1/Y AOI21X1_3/Y gnd OR2X2_2/A vdd NAND3X1
XINVX1_15 NOR2X1_2/Y gnd INVX1_15/Y vdd INVX1
XOAI21X1_10 A[2] INVX1_11/Y NOR2X1_10/Y gnd OAI21X1_10/Y vdd OAI21X1
XOAI21X1_21 NOR2X1_10/A AOI22X1_3/A OAI21X1_21/C gnd OAI21X1_21/Y vdd OAI21X1
XFILL_1_0_2 gnd vdd FILL
XNAND3X1_13 A[0] A[1] A[2] gnd INVX1_18/A vdd NAND3X1
XNOR2X1_13 INVX1_22/A NOR2X1_17/A gnd INVX1_21/A vdd NOR2X1
XINVX1_16 NOR2X1_4/Y gnd INVX1_16/Y vdd INVX1
XOAI21X1_11 A[0] A[1] A[2] gnd OAI21X1_11/Y vdd OAI21X1
XOAI21X1_22 OAI21X1_22/A NOR2X1_17/Y OAI21X1_22/C gnd BUFX2_1/A vdd OAI21X1
XFILL_4_0_0 gnd vdd FILL
XFILL_4_1 gnd vdd FILL
XNAND3X1_14 OAI21X1_10/Y AOI21X1_8/Y OAI21X1_9/Y gnd AOI21X1_9/C vdd NAND3X1
XNOR2X1_14 INVX1_21/A NOR2X1_17/B gnd NOR2X1_14/Y vdd NOR2X1
XINVX1_17 INVX1_17/A gnd INVX1_17/Y vdd INVX1
XFILL_4_0_1 gnd vdd FILL
XOAI21X1_12 OAI21X1_7/A OAI21X1_7/B INVX1_17/A gnd NOR2X1_17/B vdd OAI21X1
XNOR2X1_15 A[3] NOR2X1_15/B gnd NOR2X1_15/Y vdd NOR2X1
XNAND3X1_15 INVX1_21/A OAI21X1_15/C OR2X2_3/Y gnd NAND3X1_15/Y vdd NAND3X1
XINVX1_18 INVX1_18/A gnd INVX1_18/Y vdd INVX1
XFILL_4_0_2 gnd vdd FILL
XOAI21X1_13 XNOR2X1_1/Y OAI21X1_13/B INVX1_14/A gnd OAI21X1_13/Y vdd OAI21X1
XINVX1_19 INVX1_19/A gnd INVX1_19/Y vdd INVX1
XNOR2X1_16 BUFX2_5/A NOR2X1_16/B gnd BUFX2_6/A vdd NOR2X1
XFILL_2_1_0 gnd vdd FILL
XNAND3X1_16 AOI22X1_2/Y OAI21X1_16/Y AOI22X1_3/Y gnd NAND3X1_16/Y vdd NAND3X1
XOAI21X1_14 INVX1_21/Y OAI21X1_14/B NOR2X1_2/Y gnd OAI21X1_18/B vdd OAI21X1
XXNOR2X1_1 B[1] A[1] gnd XNOR2X1_1/Y vdd XNOR2X1
XINVX1_1 Cin gnd INVX1_1/Y vdd INVX1
XAND2X2_1 B[0] A[0] gnd NOR2X1_3/B vdd AND2X2
XNAND3X1_17 OAI21X1_7/Y AOI21X1_9/Y NOR3X1_1/Y gnd NOR2X1_16/B vdd NAND3X1
XNOR2X1_17 NOR2X1_17/A NOR2X1_17/B gnd NOR2X1_17/Y vdd NOR2X1
XFILL_2_1 gnd vdd FILL
XFILL_2_1_1 gnd vdd FILL
XOAI21X1_15 OR2X2_3/B OR2X2_3/A OAI21X1_15/C gnd OAI21X1_20/C vdd OAI21X1
XINVX1_2 ALU_Sel[1] gnd INVX1_2/Y vdd INVX1
XAND2X2_2 INVX1_7/Y B[0] gnd AND2X2_2/Y vdd AND2X2
XFILL_2_1_2 gnd vdd FILL
XOAI21X1_16 OAI21X1_16/A NOR2X1_15/Y INVX1_19/Y gnd OAI21X1_16/Y vdd OAI21X1
XINVX1_3 ALU_Sel[0] gnd INVX1_3/Y vdd INVX1
XOR2X2_1 B[0] A[0] gnd OR2X2_1/Y vdd OR2X2
XAND2X2_3 AND2X2_3/A INVX1_17/A gnd OR2X2_3/B vdd AND2X2
XOAI22X1_1 NOR2X1_5/Y OAI22X1_1/B NOR2X1_3/A OAI22X1_2/A gnd OAI22X1_1/Y vdd OAI22X1
XOAI21X1_17 NOR2X1_17/A INVX1_4/A OAI22X1_2/A gnd AOI22X1_3/D vdd OAI21X1
XOR2X2_2 OR2X2_2/A OR2X2_2/B gnd OR2X2_2/Y vdd OR2X2
XINVX1_4 INVX1_4/A gnd INVX1_4/Y vdd INVX1
XNAND2X1_20 A[3] INVX1_18/Y gnd AOI22X1_3/A vdd NAND2X1
XOAI22X1_2 OAI22X1_2/A NOR2X1_8/Y INVX1_14/A INVX1_6/A gnd OAI22X1_2/Y vdd OAI22X1
XOAI21X1_18 NOR2X1_14/Y OAI21X1_18/B OAI21X1_18/C gnd BUFX2_5/A vdd OAI21X1
XINVX1_5 ALU_Sel[2] gnd INVX1_5/Y vdd INVX1
XOR2X2_3 OR2X2_3/A OR2X2_3/B gnd OR2X2_3/Y vdd OR2X2
.ends
